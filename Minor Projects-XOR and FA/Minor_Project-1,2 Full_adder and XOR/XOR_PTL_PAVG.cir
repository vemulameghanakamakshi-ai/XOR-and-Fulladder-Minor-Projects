* XOR GATE - NMOS pass-transistor mux implementation
* Generic educational models; not process-calibrated.

.model NM NMOS (LEVEL=1 VTO=0.7 KP=120u LAMBDA=0.02)
.model PM PMOS (LEVEL=1 VTO=-0.7 KP=50u LAMBDA=0.02)

.subckt INV A Y VDD VSS
MP Y A VDD VDD PM W=4u L=1u
MN Y A VSS VSS NM W=2u L=1u
.ends INV

.subckt PTLMUX D0 D1 S Y VDD VSS
XS S SB VDD VSS INV
* NMOS-only pass mux; HIGH level may be degraded
MN0 Y SB D0 VSS NM W=2u L=1u
MN1 Y S D1 VSS NM W=2u L=1u
.ends PTLMUX

.subckt XOR_P A B Y VDD VSS
XB B BN VDD VSS INV
XA A AN VDD VSS INV
XM B BN A Y VDD VSS PTLMUX
.ends XOR_P

V1 VDD 0 5
VA A 0 0
VB B 0 PULSE(0 5 0 1n 1n 1u 2u)
XG A B Y VDD 0 XOR_P
Cload Y 0 10f
.tran 0 4u 0 1p
.save V(A) V(B) V(Y) V(VDD) I(V1)
.meas TRAN PAVG AVG (-V(VDD)*I(V1)) FROM=0 TO =4u
.meas TRAN tPLH TRIG V(B) VAL=2.5 RISE=1 TARG V(Y) VAL=2.5 RISE=1
.meas TRAN tPHL TRIG V(B) VAL=2.5 FALL=1 TARG V(Y) VAL=2.5 FALL=1
.meas TRAN tPD PARAM (tPLH+TPHL)/2
.end
