* FULL ADDER - CMOS NAND/XOR implementation
* Generic educational models; not process-calibrated.

.model NM NMOS (LEVEL=1 VTO=0.7 KP=120u LAMBDA=0.02)
.model PM PMOS (LEVEL=1 VTO=-0.7 KP=50u LAMBDA=0.02)

.subckt INV A Y VDD VSS
MP Y A VDD VDD PM W=4u L=1u
MN Y A VSS VSS NM W=2u L=1u
.ends INV

.subckt NAND2 A B Y VDD VSS
MP1 Y A VDD VDD PM W=4u L=1u
MP2 Y B VDD VDD PM W=4u L=1u
MN1 Y A NINT VSS NM W=2u L=1u
MN2 NINT B VSS VSS NM W=2u L=1u
.ends NAND2

.subckt XOR_CM A B Y VDD VSS
X1 A B N1 VDD VSS NAND2
X2 A N1 N2 VDD VSS NAND2
X3 B N1 N3 VDD VSS NAND2
X4 N2 N3 Y VDD VSS NAND2
.ends XOR_CM

.subckt FA A B CIN SUM COUT VDD VSS
X1 A B P VDD VSS XOR_CM
X2 P CIN SUM VDD VSS XOR_CM
X3 A B N1 VDD VSS NAND2
X4 P CIN N2 VDD VSS NAND2
X5 N1 N2 COUT VDD VSS NAND2
.ends FA

V1 VDD 0 5
VA A 0 PULSE(0 5 1u 1n 1n 4u 8u)
VB B 0 0
VC CIN 0 0
XFA A B CIN SUM COUT VDD 0 FA
CSUM SUM 0 10f
.tran 0 8u 0 1n
.save V(A) V(B) V(CIN) V(SUM) V(COUT) V(VDD) I(V1)
.meas TRAN PAVG AVG (-V(VDD)*I(V1)) FROM=0 TO=4u
.meas TRAN tPLH_SUM TRIG V(A) VAL=2.5 RISE=1 TARG V(SUM) VAL=2.5 RISE=1
.meas TRAN tPHL_SUM TRIG V(A) VAL=2.5 FALL=1 TARG V(SUM) VAL=2.5 FALL=1
.meas TRAN tPD_SUM PARAM (tPLH_SUM+tPHL_SUM)/2
.end
